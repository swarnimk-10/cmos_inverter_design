ADE simulation setup
Run mode: Single Run, Sweeps and Corners
Tests:
  Mylib001:inverter_tb:1: Mylib001/inverter_tb/schematic, simulator spectre
